* CE voltage-divider amplifier v1 (Lab 04)
* Generated by bjt_bias.spice_engine -- inputs are validated floats only
.include C:/Phatcharakan/GitLab1/bjt_bias/spice_models/2n3904.lib
VCC  vcc  0   12
R1   vcc  base 100000
R2   base 0   22000
RC   vcc  coll 2200
RE   emit 0   1000
Q1   coll base emit Q2N3904
CIN  vin  base 1e-05
COUT coll out  1e-05
RL   out  0    10000
VIN  vin  0   DC 0 AC 1 SIN(0 0.01 1000)
.control
set units=degrees
set wr_singlescale
op
wrdata op.txt v(base) v(emit) v(coll) @q1[ic] @q1[ib] @q1[ie]
.endc
.end
